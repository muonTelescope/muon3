* =====================================================================
* ch_opa858.cir - One channel: S13360-2050VE -> OPA858 TIA -> TLV3601
* Topology: DC-coupled anode readout. SiPM cathode at +HV via RC filter,
* anode held at virtual ground = VBOT (DAC). Negative-going output pulses.
* Rf = 2k, Cf = 2.2p  (Q ~ 0.7, f3dB ~ 50 MHz)
* Threshold = 3 p.e. nominal (-120 mV from baseline)
* =====================================================================
.include lib_frontend.lib

.param NPE_RUN=30
.param VBOT=2.40        ; TIA baseline / non-inverting reference (DAC4-7)
.param VTH=2.28         ; comparator threshold (DAC0-3): 3 p.e. below baseline
.param RFV=2k
.param CFV=2.2p

* supplies
Vdd  VDD33 0 3.3
Vhv  HVQ   0 32.4       ; HV_QUIET (Vbr+3 + VBOT offset; node value illustrative)

* DAC-derived references (modeled as filtered sources)
Vvbot VBOTN 0 {VBOT}
Rvb VBOTN VBOTF 1k
Cvb VBOTF 0 100n
Vvth VTHN 0 {VTH}
Rvt VTHN VTHF 1k
Cvt VTHF 0 100n

* per-channel HV isolation:  HVQ -> 100k -> CATH, 100n local reservoir
Rhv HVQ CATH 100k
Chv CATH 0 100n

* SiPM: anode straight into TIA summing node (DC coupled)
Xsipm IN CATH SIPM_2050VE NPE={NPE_RUN} T0=200n

* input series protection + clamps (BAV99 ~ 1.5p modeled as cap)
Rser IN INA 10
Dclp1 INA VDD33 DCLAMP
Dclp2 0 INA DCLAMP
.model DCLAMP D(IS=1n CJO=1.5p RS=1)

* TIA
Xamp VBOTF INA OUT VDD33 0 OPA858
Rf INA OUT {RFV}
Cf INA OUT {CFV}

* comparator: INP=TIA out, INN=threshold  -> quiescent HIGH, pulse LOW
Xcmp OUT VTHF CMPO VDD33 TLV3601
* series resistor into FPGA pin, pin cap
Rgpio CMPO FPGA 33
Cpin FPGA 0 6p

.control
  set wr_vecnames
  set wr_singlescale
  * --- single-shot waveform runs for plotting (NPE = 1,3,10,30,100,500)
  let npes = vector(6)
  let npes[0]=1  $ let npes[1]=3 $ let npes[2]=10
  let npes[3]=30 $ let npes[4]=100 $ let npes[5]=500
  let i = 0
  while i < 6
    alterparam NPE_RUN = $&npes[i]
    reset
    tran 0.1n 600n
    wrdata /home/claude/muon/sim/wave_858_{$&i}.csv v(out) v(cmpo) v(ina)
    let i = i + 1
  end
.endc
.end
