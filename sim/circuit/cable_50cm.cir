* =====================================================================
* cable_50cm.cir - 50 cm hybrid-cable signal path study
* Rev 2 (2026-07-11):
*   - now a genuinely LOSSY line (LTRA model with R/L/C per meter);
*     rev 1 used an ideal T-line despite the "lossy" label
*   - complete testbench: the same SiPM pulse drives (a) a direct path
*     and (b) the 50 cm cable path, both into full OPA858 TIA stages,
*     so the cable's effect on amplitude/shape is directly comparable
*   - rev 1 left the board-side node floating (no TIA), which cannot
*     simulate; batch-safe output via wrdata
* Cable assumption: RG-174-class 50 ohm coax pair inside the hybrid
* bundle: ~0.3 ohm/m conductor R at DC (higher with skin effect),
* L=253 nH/m, C=101 pF/m -> Z0=50, v=0.66c, one-way delay ~2.5 ns.
* NOTE: with an 82 ns SiPM decay the pulse is slow compared with the
* cable; the interesting effects are the added ~50 pF and the ~2.5 ns
* delay, not transmission-line ringing of the main lobe.
* =====================================================================
.include muon3_frontend.lib

.param NPE=30
.param T0=100n
.param VBOT=1.80
.param RF=2000
.param CF=3.3p

Vana VANA_R 0 5.0
Vhv  HVQ 0 28.7
Vvbot VBOTF 0 {VBOT}

* ---------------- Path A: direct (reference) ------------------------------
RhvA  HVQ CATHA 10k
ChvA  CATHA 0 100n
XsipA INA0 CATHA MICROFC_30035 NPE={NPE} T0={T0}
RserA INA0 INA 10
XampA VBOTF INA OUTA VANA_R 0 OPA858
RfA   INA OUTA {RF}
CfA   INA OUTA {CF}

* ---------------- Path B: 50 cm lossy cable -------------------------------
RhvB  HVQ CATHB 10k
ChvB  CATHB 0 100n
XsipB PANB CATHB MICROFC_30035 NPE={NPE} T0={T0}
* Panel-side pigtail resistance
RpigB PANB SIG1 0.3
OLINE SIG1 0 SIG2 0 CABLE50
.model CABLE50 LTRA(R=0.6 L=253n C=101p LEN=0.5)
RserB SIG2 INB 10
XampB VBOTF INB OUTB VANA_R 0 OPA858
RfB   INB OUTB {RF}
CfB   INB OUTB {CF}

.control
  set wr_vecnames
  set wr_singlescale
  shell mkdir -p results
  tran 0.2n 1000n
  wrdata results/cable_compare.csv v(OUTA) v(OUTB) v(INA) v(INB)
  echo "CABLE MODEL RUN COMPLETE"
.endc
.end
