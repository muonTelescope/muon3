* =====================================================================
* afe_dual_threshold.cir - Muon3 single channel with dual comparators
* DC-coupled MicroFC-30035 -> OPA858 TIA -> low + high TLV3601
* Includes charge injection port and basic protection.
* Baseline for 2026 muon3 P0 design (update params from real panel data).
* =====================================================================
.include muon3_frontend.lib

* ---------------- Parameters (override on command line or alterparam) ----
.param NPE=15              ; photoelectrons (start low for single-p.e. scans)
.param VOV=3.0             ; overvoltage (adjusts effective QPE in practice)
.param VBOT=1.80           ; new baseline for clean 5V or adjusted 3.3V rail (example)
.param VTH_LOW=1.68        ; low (physics) threshold ~3 p.e. below baseline
.param VTH_HIGH=1.50       ; high (shower discrimination) threshold
.param RF=2000
.param CF=2.2p
.param T0=200n             ; pulse arrival
.param VANA=3.3            ; or 5.0 for clean analog rail

* Supplies
Vdd   VDD 0 {VANA}
Vgnd  0   0 0
Vhv   HVQ 0 29.5           ; ~ Vbr + Vov + VBOT offset for MicroFC (~27+3+~0)

* DAC references (filtered)
Vvbot VBOTN 0 {VBOT}
Rvb   VBOTN VBOTF 1k
Cvb   VBOTF 0 100n

Vthl  VTHL_N 0 {VTH_LOW}
Rthl  VTHL_N VTHL_F 1k
Cthl  VTHL_F 0 100n

Vthh  VTHH_N 0 {VTH_HIGH}
Rthh  VTHH_N VTHH_F 1k
Cthh  VTHH_F 0 100n

* HV filter + local reservoir (per channel or shared quiet rail)
Rhv   HVQ CATH 100k
Chv   CATH 0 100n

* Panel connector / cable interface point (see cable_50cm.cir for full model)
* For now direct: anode from SiPM model
* SiPM (anode to summing node)
Xsipm IN CATH MICROFC_30035 NPE={NPE} T0={T0} QPE=480f CT=400p

* Protection / summing node
Rser  IN INA 10
Dclp1 INA VDD BAV99_CLAMP
Dclp2 0   INA BAV99_CLAMP

* TIA
Xamp  VBOTF INA OUT VDD 0 OPA858
Rf    INA OUT {RF}
Cf    INA OUT {CF}

* Dual comparators (active-low outputs)
XcmpL OUT VTHL_F CMPL VDD 0 TLV3601
XcmpH OUT VTHH_F CMPH VDD 0 TLV3601

* Series damping into FPGA (iCE40 pins)
Rgl   CMPL FPAL 33
Cgl   FPAL 0 6p
Rgh   CMPH FPAH 33
Cgh   FPAH 0 6p

* ---------------- Charge injection hook (DNP or used in cal mode) ------------
* Drive INJ node with a fast voltage step (e.g. 0->1V through 1-5 pF)
* or use a current source for controlled charge.
Xinj  INJ INA CHARGE_INJ CINJ=1.5p
* Example test source (comment out for normal runs):
* Vstep INJ 0 PULSE(0 1.0 100n 2n 2n 50n 1)

* ---------------- Decoupling (place at package pins in layout) -------------
Cdec1 VDD 0 100n
Cdec2 VDD 0 2.2u

.control
  set wr_vecnames
  set wr_singlescale
  shell mkdir -p results
  reset
  tran 0.2n 800n
  wrdata results/wave_dual.csv v(OUT) v(CMPL) v(CMPH) v(INA) v(FPAL)
  echo "NGSPICE SINGLE RUN COMPLETE"
.endc
.end
