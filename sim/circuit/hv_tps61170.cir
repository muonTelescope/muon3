* =====================================================================
* hv_tps61170.cir - Behavioral model of TPS61170 SiPM bias boost + filter
* Target: ~30 V for MicroFC-30035 (adjust for exact overvoltage + temp coeff)
* Includes DAC trim, OVP concept, per-channel RC filtering, readback divider.
* For noise / transient studies only; not a full switched-mode sim.
* =====================================================================

.param VOUT_TARGET=29.8
.param VTRIM=1.0          ; 0-3.3 V DAC trim (higher trim usually lowers output on typical FB)
.param RFB1=270k
.param RFB2=10k
.param RTRIM=100k

* Input rail (from protected 12 V or 5 V PD bus)
Vin VIN 0 12

* Simplified boost: voltage-controlled voltage source + output resistance
* (real part switches at ~1.2 MHz; use for averaged + ripple injection)
Eboost RAW 0 VIN 0 3.0     ; crude step-up; replace with proper model if needed
Rout RAW OUTB 5
Cbulk OUTB 0 2.2u

* Output filter chain (critical for AFE quietness)
L2   OUTB F1 100u
C11  F1 0 1u
R10  F1 F2 1k
C12  F2 0 2.2u

* Trim network (typical inverting trim on FB)
Rfb1 F2 FB {RFB1}
Rfb2 FB 0 {RFB2}
Rtr  TRIM FB {RTRIM}
Vtrim TRIM 0 {VTRIM}

* Final quiet HV rail (one per channel or shared)
Rquiet F2 HV_QUIET 100
Cquiet HV_QUIET 0 100n

* HV monitor divider (to ADC, ~ /17 for 30 V -> ~1.76 V)
Rhmon1 HV_QUIET HVMON 1MEG
Rhmon2 HVMON 0 62k

* Simple OVP clamp idea (Zener or active in real design)
DOVP HV_QUIET 0 D( BV=35 )

.control
  dc Vtrim 0 3.3 0.1
  plot v(HV_QUIET)
  tran 1u 100u
  plot v(HV_QUIET) v(HVMON)
  wrdata hv_sweep.csv v(HV_QUIET) v(HVMON) v(F2)
  echo "HV model: adjust RFB1/RFB2 + VTRIM to hit target. Check ripple feedthrough into AFE."
.endc
.end
