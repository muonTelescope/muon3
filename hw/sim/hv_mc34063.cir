* Muon3 bias supply: MC34063 (behavioural) + BSS123 + 150uH + LL4148, LC post-filter, PWM trim
* Control per MC34063A datasheet: switch on while oscillator is in its charge phase AND FB < 1.25 V AND I_L < Ipk.
* Oscillator: CT 1 nF -> ~33 kHz, charge:discharge 6.5:1 [DS 7.5]; Ipk = 0.3 V / 1 ohm.
.param VTRIM=0.8
V5 v5 0 5
Rsc v5 ipk 1
Vsen ipk ipk2 0
L1 ipk2 lx 150u
Rdcr lx sw 2.4
* oscillator: 30 us period, 26 us charge (switch-enable) phase
Vosc osc 0 PULSE(0 1 0 10n 10n 26u 30u)
* current-limit latch: node lat recharges while the oscillator discharges, is cleared when I_L reaches Ipk
Blatch 0 lat I = ( v(osc) < 0.5 ) ? (1 - v(lat)) * 1m : ( ( i(Vsen) > 0.3 ) ? -v(lat) * 1m : 0 )
Clat lat 0 1n IC=1
Rlat lat 0 1G
Bgate graw 0 V = ( v(osc) > 0.5 && v(fb) < 1.25 && v(lat) > 0.5 ) ? 1 : 0
Rg graw g 1k
Cg g 0 20p
* BSS123 as a gate-controlled conductance (2 ohm on)
Gsw sw 0 cur = v(sw) * v(g) / 2 + v(sw) * 1e-9
D1 sw raw LL4148
.model LL4148 D(IS=2.5n N=1.9 RS=0.6 CJO=4p TT=5n BV=100)
Craw raw 0 1.1u
L2 raw hvl 1m
Rl2 hvl hv 20
Chv hv 0 1u
* feedback: 2 x 510k over 22k, trim through 47k from the RC-filtered PWM
Ru raw fb 1.02Meg
Rl fb 0 22k
Rd vt fb 47k
Vt vt 0 {VTRIM}
* loads: HV monitor 2.075M, 4 channels (47k + 100n, SiPM ~1 uA dark current each)
Rmon hv 0 2.075Meg
Rj1 hv j1 47k
Cj1 j1 0 100n
Ij1 j1 0 4u
.control
tran 0.2u 40m 0 0.2u uic
meas tran vraw AVG v(raw) FROM=30m TO=40m
meas tran vhv AVG v(hv) FROM=30m TO=40m
meas tran rawpp PP v(raw) FROM=30m TO=40m
meas tran hvpp PP v(hv) FROM=30m TO=40m
meas tran j1pp PP v(j1) FROM=30m TO=40m
meas tran t60 WHEN v(hv)=60 RISE=1
wrdata /private/tmp/claude-501/-Users-sawaiz-muon3/eeda6667-dd5d-4d9f-8445-42cac8b5834b/scratchpad/hv_wave.txt v(raw) v(hv)
.endc
.end
